* GF180MCU Op-Amp Interactive GUI Simulation
.lib "gf180mcu.lib" tt
.global vdd gnd

Vdd vdd 0 DC 3.3
Rbias vdd vbias 40k
M8 vbias vbias 0 0 nfet_03v3 W=10.0u L=0.5u
M5 n_tail vbias 0 0 nfet_03v3 W=20.0u L=0.5u

Vicm icm 0 DC 1.65
Vin_p inp icm DC 0 AC 0.5
Vin_m inm icm DC 0 AC -0.5

M1 n1 inm n_tail 0 nfet_03v3 W=10.0u L=0.5u
M2 n2 inp n_tail 0 nfet_03v3 W=10.0u L=0.5u
M3 n1 n1 vdd vdd pfet_03v3 W=20.0u L=0.5u
M4 n2 n1 vdd vdd pfet_03v3 W=20.0u L=0.5u

M6 vout n2 vdd vdd pfet_03v3 W=40.0u L=0.5u
M7 vout vbias 0 0 nfet_03v3 W=40.0u L=0.5u

Rz n2 n_cc 1k
Cc n_cc vout 1.2p
Cload vout 0 10p

.control
ac dec 20 10 1G
run
plot vdb(vout) title "GF180MCU Op-Amp: AC Gain (dB)" ylimit -40 50
plot vp(vout) title "GF180MCU Op-Amp: Phase (Degrees)"
.endc
.end
